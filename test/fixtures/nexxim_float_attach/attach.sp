* FLOAT file-model attach-law coupon (generated by gen.jl)
RPort1 1 0 PORTNUM=1 RZ=50 IZ=0
.PORT 1 0 1 RPort1
RPort2 2 0 PORTNUM=2 RZ=50 IZ=0
.PORT 2 0 2 RPort2
SE 1 0 2 0 3 4 MNAME=emmod
SM 3 5 4 5 MNAME=dev
Rb3 3 0 1e9
Rb4 4 0 1e9
Rb5 5 0 1e9
.MODEL emmod SP N=3 FSTART=1.0e8 FSTOP=1.5e8 VALTYPE=CARTESIAN MATRIX=NONSYMMETRIC
+ DATA=[ 2
+ 0.333331960498201 -0.0019059840560457335  0.6666150167281102 -0.008391721317725196  0.6666434307869273 -0.005167785768172815
+ 0.6666150167281106 -0.00839172131770625  0.3333319604981986 -0.001905984056051714  -0.6666434307869286 0.005167785768197783
+ 0.6666434307869274 -0.005167785768191764  -0.6666434307869283 0.005167785768178835  0.3333435510368534 0.001318081908549275
+ 0.3333302430391334 -0.002859082357469525  0.6665504561789998 -0.01258719004259803  0.6666143868772747 -0.007751512509142881
+ 0.6665504561789998 -0.012587190042588552  0.33333024303913317 -0.0028590823574716207  -0.6666143868772748 0.007751512509154474
+ 0.6666143868772745 -0.0077515125091523595  -0.666614386877275 0.007751512509144996  0.33335632265711435 0.001977035315173195
+ ]
.MODEL dev SP N=2 FSTART=1.0e8 FSTOP=1.5e8 VALTYPE=CARTESIAN MATRIX=NONSYMMETRIC
+ DATA=[ 2
+ 0.08 0.0  0.9 -0.0
+ 0.8600000000000001 -0.0  0.12 0.0
+ 0.07 0.0  0.925 -0.0
+ 0.89 -0.0  0.105 0.0
+ ]
.LNA POI 2 1.0e8 1.5e8 flag='LNA'
.print LNA S(1,1) S(2,1) S(1,2) S(2,2)
.end
