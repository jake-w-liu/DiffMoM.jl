* Literal installed Spectre subset translated for ngspice AC proof
.subckt _1nH_oct_inductor 1 4 REF
L_1 1 2 9.1167346389999996e-10
R_2 2 3 2.7336596775423998
C_3 1 3 1.4686629779999999e-16
L_4 3 4 4.757452211e-11
R_5 3 4 3.1661357096091001
C_6 1 5 1.250410265e-14
R_7 5 REF 254.57849585113999
C_8 5 REF 1.4496235109999999e-14
C_9 4 6 1.014429984e-14
R_10 6 REF 359.45826103001002
C_11 6 REF 7.8045723459999996e-15
.ends _1nH_oct_inductor
