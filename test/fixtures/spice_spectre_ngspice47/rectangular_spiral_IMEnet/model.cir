* Literal installed Spectre subset translated for ngspice AC proof
.subckt rectangular_spiral_IMEnet 1 2 3 REF
L_1 1 4 6.4382387749999999e-11
R_2 1 4 0.92240631618089997
R_3 4 5 4.3175498377021002
L_4 2 6 1.10345517e-10
R_5 2 6 584.26442594855996
R_6 6 7 4.6205523355895002
C_7 1 2 5.2898766589999997e-14
L1_8 5 11 1.6563768405000001e-09
L2_8 11 7 1.5629346850999999e-09
R_9 11 3 0.13596451598039999
C_10 1 8 3.6379791650000003e-14
R_11 8 REF 2072.6011396367999
C_12 8 REF 3.2959325379999998e-14
C_13 2 9 3.8963024210000002e-14
R_14 9 REF 1978.7544147701001
C_15 9 REF 1.9596655339999999e-14
C_16 11 10 7.3911175580000004e-14
R_17 10 REF 1466.2097275829999
C_18 10 REF 1.59140715e-12
K_M_8 L1_8 L2_8 0.78633848308370002
.ends rectangular_spiral_IMEnet
