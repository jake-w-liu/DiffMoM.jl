Independent loaded-wave installed Spectre export drive
.include model.cir
Xdevice n1 n2 n3 0 rectangular_spiral_IMEnet
Vdrive1 src1 0 DC 0 AC 14.142135623730951
Rref1 src1 n1 50
Vdrive2 src2 0 DC 0 AC 0
Rref2 src2 n2 75
Vdrive3 src3 0 DC 0 AC 0
Rref3 src3 n3 100
.control
set wr_singlescale
set wr_vecnames
set numdgt=17
ac lin 19 1000000 20000000000
wrdata wave0.dat v(n1) i(Vdrive1) v(n2) i(Vdrive2) v(n3) i(Vdrive3)
quit
.endc
.end
