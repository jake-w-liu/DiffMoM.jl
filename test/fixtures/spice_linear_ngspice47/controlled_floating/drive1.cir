Independent actual ngspice SPICE ingestion drive
.include "C:\Users\User\DiffMoM.jl\validation\planar_audit\..\spice_ingestion\linear_hcOAu3\controlled.lib"
Xuut p1 p2 floating_ref controlled
Vcommon floating_ref 0 DC 0 AC 0.7 37
Vdrv1 drv1 floating_ref DC 0 AC 14.142135623730951
Rdrv1 drv1 p1 50.0
Vdrv2 drv2 floating_ref DC 0 AC 0
Rdrv2 drv2 p2 75.0
.control
set wr_singlescale
set wr_vecnames
set numdgt=17
ac lin 21 1000.0 1.0e10
wrdata drive1.dat v(p1)-v(floating_ref) v(p2)-v(floating_ref)
quit
.endc
.end
