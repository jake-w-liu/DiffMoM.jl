Actual loaded-wave linear line proof
.include lc.lib
Xdev n1 n2 n3 n4 device
Vdrive1 src1 n2 DC 0 AC 0
Rport1 src1 n1 50.0
Vdrive2 src2 n4 DC 17.320508075688775 AC 17.320508075688775
Rport2 src2 n3 75.0
Vgauge1 n2 0 DC 0 AC 0
Vgauge2 n4 0 DC 0 AC 0
.control
set wr_singlescale
set wr_vecnames
set numdgt=17
op
wrdata lc_device_zero_dc_drive2.cir.dat v(n1,n2) i(Vdrive1) v(n3,n4) i(Vdrive2)
quit
.endc
.end
