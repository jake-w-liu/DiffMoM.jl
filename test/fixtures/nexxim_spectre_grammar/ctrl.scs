; spectre smoke deck
simulator lang=spectre
parameters rin=50 rload=100
subckt gainstage (a b)
parameters rg=50
Gm (m 0) vccs (a 0) vccs=0.01
Rm (m 0) resistor r=rg
Ev (b 0) vcvs (m 0) vcvs=1.0
Rl (b 0) resistor r=rload
ends
subckt top (in out)
X1 (in n1) gainstage
Vs (n1 n2) vsource type=dc dc=0
F1 (out 0) cccs probe=Vs cccs=0.5
H1 (n3 0) ccvs probe=Vs ccvs=10
Rh (n3 n2) resistor r=5
C1 (n2 out) capacitor c=1p
R2 (out 0) resistor r=rload
Ix (out 0) isource type=dc dc=0
ends
