Actual loaded-wave K hierarchy proof
.include isolated.lib
Xdevice n1 n2 n3 n4 isolation
Vdrive1 src1 n3 DC 0 AC 14.142135623730951
Rport1 src1 n1 50.0
Vdrive2 src2 n4 DC 0 AC 0
Rport2 src2 n2 75.0
Vgauge1 n3 0 DC 0 AC 0
Vgauge2 n4 0 DC 0 AC 0
.control
set wr_singlescale
set wr_vecnames
set numdgt=17
ac lin 23 1.0e6 2.0e10
wrdata isolation_wave1.cir.dat v(n1,n3) i(Vdrive1) v(n2,n4) i(Vdrive2)
quit
.endc
.end
