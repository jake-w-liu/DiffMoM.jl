Independent ngspice admittance drive 1
.include model.cir
Xmodel n1 n2 nref diffmom_nport
Vcommon nref 0 DC 0 AC 1 37
Vdrive1 n1 nref DC 0 AC 1
Vdrive2 n2 nref DC 0 AC 0
.control
set wr_singlescale
set wr_vecnames
set numdgt=17
ac lin 37 1.0e6 3.0e10
wrdata drive1.dat i(Vdrive1) i(Vdrive2)
quit
.endc
.end
