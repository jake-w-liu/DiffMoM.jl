* DiffMoM real stable N-port admittance model
* relative_rms_error: 1.840921429830726e-15
* sampled_passive: true  checked_margin: 0.017970893805822896  conductance_shift: 0.0
* globally_passive: true  certificate: positive_residues  capacitance_adjustment: 8.395140627083008e-28
.subckt diffmom_nport p1 p2 dm_ref
Gd1_1 p1 dm_ref p1 dm_ref 0.019999999999999966
Gd1_2 p1 dm_ref p2 dm_ref -0.004999999999999994
Gd2_1 p2 dm_ref p1 dm_ref -0.004999999999999994
Gd2_2 p2 dm_ref p2 dm_ref 0.02999999999999997
Edm_copy1 dm_v1 0 p1 dm_ref 1
Vdm_sense1 dm_v1 dm_c1 0
Cdm_affine1 dm_c1 0 1
Fdm_affine1_1 p1 dm_ref Vdm_sense1 1.0000000000000014e-12
Fdm_affine2_1 p2 dm_ref Vdm_sense1 -2.000000000000003e-13
Edm_copy2 dm_v2 0 p2 dm_ref 1
Vdm_sense2 dm_v2 dm_c2 0
Cdm_affine2 dm_c2 0 1
Fdm_affine1_2 p1 dm_ref Vdm_sense2 -2.000000000000003e-13
Fdm_affine2_2 p2 dm_ref Vdm_sense2 2.000000000000002e-12
Cdm_u1 dm_u1 0 1
Rdm_u1 dm_u1 0 4.999999999999886e-10
Gindm_u1 dm_u1 0 p1 dm_ref -1
Gsdm_u1_1 p1 dm_ref dm_u1 0 1.000000000000013e8
Gsdm_u1_2 p2 dm_ref dm_u1 0 -2.0000000000000246e7
Cdm_u2 dm_u2 0 1
Rdm_u2 dm_u2 0 4.999999999999886e-10
Gindm_u2 dm_u2 0 p2 dm_ref -1
Gsdm_u2_1 p1 dm_ref dm_u2 0 -2.0000000000000246e7
Gsdm_u2_2 p2 dm_ref dm_u2 0 8.000000000000107e7
.ends diffmom_nport
